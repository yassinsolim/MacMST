* M5P8 ANALYSIS ONLY. Not a construction schematic or qualified device model.
* Sources belong to the external bench deck, never to the observer.
* TVS and rail diodes are generic sensitivity models, not manufacturer models.
.subckt AUX_RX_ONLY AUXP AUXN VDD AGND RXD VIO DGND params:
+ RBRANCH=1k RLIMIT=2.2k CSENSE=2.2p RBIAS=1Meg
+ CIN=2.5p CPROT=0.5p CSTRAY=0.5p MISMATCH=0 CAPDELTA=0 INDELTA=0 OFFSET=0
CSTRAYP AUXP AGND {CSTRAY}
CSTRAYN AUXN AGND {CSTRAY}
RBRANCHP AUXP PROTP {RBRANCH*(1+MISMATCH)}
RBRANCHN AUXN PROTN {RBRANCH*(1-MISMATCH)}
CPROTP PROTP AGND {CPROT}
CPROTN PROTN AGND {CPROT}
BTVSP PROTP AGND I={max(V(PROTP,AGND)-6.4,0)/0.57+min(V(PROTP,AGND)+6.4,0)/0.57}
BTVSN PROTN AGND I={max(V(PROTN,AGND)-6.4,0)/0.57+min(V(PROTN,AGND)+6.4,0)/0.57}
CSENSEP PROTP COUPLEDP {CSENSE+CAPDELTA}
CSENSEN PROTN COUPLEDN {CSENSE-CAPDELTA}
RLIMITP COUPLEDP INP {RLIMIT*(1+MISMATCH)}
RLIMITN COUPLEDN INN {RLIMIT*(1-MISMATCH)}
RBIASP INP BIAS {RBIAS*(1+MISMATCH)}
RBIASN INN BIAS {RBIAS*(1-MISMATCH)}
CINP INP AGND {CIN+INDELTA}
CINN INN AGND {CIN-INDELTA}
DUPPERP INP VDD DRAIL
DUPPERN INN VDD DRAIL
DLOWERP AGND INP DRAIL
DLOWERN AGND INN DRAIL
.model DRAIL D(Is=1p N=1 Rs=10 Cjo=0)
RBIASHIGH VDD BIAS 10k
RBIASLOW BIAS AGND 10k
CBIAS BIAS AGND 100n
CDECOUPLE VDD AGND 100n
CBULK VDD AGND 1u
BCOMP CMP AGND V={V(VDD,AGND)/2*(1+tanh(1000*(V(INP,INN)-OFFSET)))}
* Ideal forward-only digital boundary; not an ISO7710 safety/timing model.
BISOLATE RXD DGND V={V(VIO,DGND)/2*(1+tanh(100*(V(CMP,AGND)-1.0)))}
.ends AUX_RX_ONLY
